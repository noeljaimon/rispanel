# Ansys Electronics Desktop project, version 2025.2
materials:
  vacuum: permittivity=1
  FR4_epoxy: permittivity=4.4 dielectric_loss_tangent=0.02
  air: permittivity=1.0006 permeability=1.0000004

design HFSSDesign1 (HFSS, HFSS Terminal Network, model units mm)
variables:
  h = 1.6mm
  larm = 25mm
  warm = 6mm
  wfeed = 4mm
  lfeed = 10mm
  lgap = 7mm
  wgap = 6mm
  lsub = 80mm
  wsub = 80mm
geometry:
  subs [FR4_epoxy] = box(corner=(-lsub/2, -wsub/2+10mm, 0mm), size=(lsub, wsub, h))
  Port = rectangle(corner=(-2mm, -40mm, 0mm), z_size=1.6mm, x_size=4mm)
  Box1 [air] = box(corner=(-75mm, -75mm, -50mm), size=(150mm, 150mm, 100mm))
  Rectangle9 = rectangle(corner=(-wfeed/2, warm/2, h), x_size=larm, y_size=-warm)
  Rectangle10 = rectangle(corner=(-wfeed/2, -warm/2, h), x_size=wfeed, y_size=-lfeed)
  Rectangle11 = rectangle(corner=(wgap/2, -(lfeed+warm/2), h), x_size=-wgap, y_size=-lgap)
  Rectangle12 = rectangle(corner=(-wfeed/2, -(warm/2+lfeed+lgap), h), x_size=wfeed, y_size=-lfeed)
  Rectangle13 = rectangle(corner=(wfeed/2, -warm/2, 0mm), x_size=-larm, y_size=warm)
  Rectangle14 = rectangle(corner=(-wfeed/2, -warm/2, 0), x_size=wfeed, y_size=-lfeed)
  Rectangle15 = rectangle(corner=(wgap/2, -(lfeed+warm/2), 0mm), x_size=-wgap, y_size=-lgap)
  Rectangle16 = rectangle(corner=(-wfeed/2, -(warm/2+lfeed+lgap), 0mm), x_size=wfeed, y_size=-lfeed)
  Box2 [FR4_epoxy] = box(corner=(0mm, 0mm, 10mm), size=(80mm, 80mm, 1.6mm))
  Box2.move(-40mm, -40mm, 0mm)
  Box2.move(0mm, 0mm, -6.6mm)
  Box2.move(-40mm, 0mm, 3.4mm)
  Box2.move(90mm, 0mm, -5mm)
  Box2.move(1mm, -0.375mm, 2.2mm)
  Box2.move(-49.5mm, 0.375mm, 4.4mm)
  Box2.move(-1.5mm, 0mm, -10mm)
  Box2.move(0mm, 0mm, 5mm)
  Box2.rotate(axis=X, angle=90deg)
  Box2.rotate(axis=X, angle=180deg)
  Box2.rotate(axis=X, angle=-270deg)
  Rectangle1 = rectangle(corner=(50.25mm, 68.75mm, 11.6mm), x_size=19.5mm, y_size=1mm)
  Rectangle19 = rectangle(corner=(59mm, 68.75mm, 11.6mm), x_size=2mm, y_size=1mm)
  Rectangle1.subtract(Rectangle19)
  Rectangle1_1, Rectangle1_2 = Rectangle1.duplicate_along_line(step=(-0.25mm, -20mm, 0.4mm), total=3)
  Rectangle1_3, Rectangle1_4 = Rectangle1.duplicate_along_line(step=(-20mm, 0mm, 0mm), total=3)
  Rectangle1.move(-40mm, -40mm, 0mm)
  Rectangle1.move(0mm, 0mm, -6.6mm)
  Rectangle1.move(-40mm, 0mm, 3.4mm)
  Rectangle1.move(90mm, 0mm, -5mm)
  Rectangle1.move(1mm, -0.375mm, 2.2mm)
  Rectangle1.move(-49.5mm, 0.375mm, 4.4mm)
  Rectangle1.move(-1.5mm, 0mm, -10mm)
  Rectangle1.move(0mm, 0mm, 5mm)
  Rectangle1.rotate(axis=X, angle=90deg)
  Rectangle1.rotate(axis=X, angle=180deg)
  Rectangle1.rotate(axis=X, angle=-270deg)
  Rectangle2 = rectangle(corner=(50.25mm, 50.25mm, 11.6mm), x_size=19.5mm, y_size=1mm)
  Rectangle20 = rectangle(corner=(59mm, 50.25mm, 11.6mm), x_size=2mm, y_size=1mm)
  Rectangle2.subtract(Rectangle20)
  Rectangle2_1, Rectangle2_2 = Rectangle2.duplicate_along_line(step=(-0.25mm, -20mm, 0.4mm), total=3)
  Rectangle2_3, Rectangle2_4 = Rectangle2.duplicate_along_line(step=(-20mm, 0mm, 0mm), total=3)
  Rectangle2.move(-40mm, -40mm, 0mm)
  Rectangle2.move(0mm, 0mm, -6.6mm)
  Rectangle2.move(-40mm, 0mm, 3.4mm)
  Rectangle2.move(90mm, 0mm, -5mm)
  Rectangle2.move(1mm, -0.375mm, 2.2mm)
  Rectangle2.move(-49.5mm, 0.375mm, 4.4mm)
  Rectangle2.move(-1.5mm, 0mm, -10mm)
  Rectangle2.move(0mm, 0mm, 5mm)
  Rectangle2.rotate(axis=X, angle=90deg)
  Rectangle2.rotate(axis=X, angle=180deg)
  Rectangle2.rotate(axis=X, angle=-270deg)
  C1 = rectangle(corner=(59mm, 50.25mm, 11.6mm), x_size=0.5mm, y_size=1mm)
  C1_1, C1_2 = C1.duplicate_along_line(step=(-0.25mm, -20mm, 0.4mm), total=3)
  C1_3, C1_4 = C1.duplicate_along_line(step=(-20mm, 0mm, 0mm), total=3)
  C1.move(-40mm, -40mm, 0mm)
  C1.move(0mm, 0mm, -6.6mm)
  C1.move(-40mm, 0mm, 3.4mm)
  C1.move(90mm, 0mm, -5mm)
  C1.move(1mm, -0.375mm, 2.2mm)
  C1.move(-49.5mm, 0.375mm, 4.4mm)
  C1.move(-1.5mm, 0mm, -10mm)
  C1.move(0mm, 0mm, 5mm)
  C1.rotate(axis=X, angle=90deg)
  C1.rotate(axis=X, angle=180deg)
  C1.rotate(axis=X, angle=-270deg)
  C2 = rectangle(corner=(60.5mm, 50.25mm, 11.6mm), x_size=0.5mm, y_size=1mm)
  C2_1, C2_2 = C2.duplicate_along_line(step=(-0.25mm, -20mm, 0.4mm), total=3)
  C2_3, C2_4 = C2.duplicate_along_line(step=(-20mm, 0mm, 0mm), total=3)
  C2.move(-40mm, -40mm, 0mm)
  C2.move(0mm, 0mm, -6.6mm)
  C2.move(-40mm, 0mm, 3.4mm)
  C2.move(90mm, 0mm, -5mm)
  C2.move(1mm, -0.375mm, 2.2mm)
  C2.move(-49.5mm, 0.375mm, 4.4mm)
  C2.move(-1.5mm, 0mm, -10mm)
  C2.move(0mm, 0mm, 5mm)
  C2.rotate(axis=X, angle=90deg)
  C2.rotate(axis=X, angle=180deg)
  C2.rotate(axis=X, angle=-270deg)
  L = rectangle(corner=(59.5mm, 50.25mm, 11.6mm), x_size=0.5mm, y_size=1mm)
  L_1, L_2 = L.duplicate_along_line(step=(-0.25mm, -20mm, 0.4mm), total=3)
  L_3, L_4 = L.duplicate_along_line(step=(-20mm, 0mm, 0mm), total=3)
  L.move(-40mm, -40mm, 0mm)
  L.move(0mm, 0mm, -6.6mm)
  L.move(-40mm, 0mm, 3.4mm)
  L.move(90mm, 0mm, -5mm)
  L.move(1mm, -0.375mm, 2.2mm)
  L.move(-49.5mm, 0.375mm, 4.4mm)
  L.move(-1.5mm, 0mm, -10mm)
  L.move(0mm, 0mm, 5mm)
  L.rotate(axis=X, angle=90deg)
  L.rotate(axis=X, angle=180deg)
  L.rotate(axis=X, angle=-270deg)
  R = rectangle(corner=(60mm, 50.25mm, 11.6mm), x_size=0.5mm, y_size=1mm)
  R_1, R_2 = R.duplicate_along_line(step=(-0.25mm, -20mm, 0.4mm), total=3)
  R_3, R_4 = R.duplicate_along_line(step=(-20mm, 0mm, 0mm), total=3)
  R.move(-40mm, -40mm, 0mm)
  R.move(0mm, 0mm, -6.6mm)
  R.move(-40mm, 0mm, 3.4mm)
  R.move(90mm, 0mm, -5mm)
  R.move(1mm, -0.375mm, 2.2mm)
  R.move(-49.5mm, 0.375mm, 4.4mm)
  R.move(-1.5mm, 0mm, -10mm)
  R.move(0mm, 0mm, 5mm)
  R.rotate(axis=X, angle=90deg)
  R.rotate(axis=X, angle=180deg)
  R.rotate(axis=X, angle=-270deg)
  Rectangle21 = rectangle(corner=(69.75mm, 68.75mm, 11.6mm), x_size=-1mm, y_size=-17.5mm)
  Rectangle21_1, Rectangle21_2 = Rectangle21.duplicate_along_line(step=(-0.25mm, -20mm, 0.4mm), total=3)
  Rectangle21_3, Rectangle21_4 = Rectangle21.duplicate_along_line(step=(-20mm, 0mm, 0mm), total=3)
  Rectangle21.move(-40mm, -40mm, 0mm)
  Rectangle21.move(0mm, 0mm, -6.6mm)
  Rectangle21.move(-40mm, 0mm, 3.4mm)
  Rectangle21.move(90mm, 0mm, -5mm)
  Rectangle21.move(1mm, -0.375mm, 2.2mm)
  Rectangle21.move(-49.5mm, 0.375mm, 4.4mm)
  Rectangle21.move(-1.5mm, 0mm, -10mm)
  Rectangle21.move(0mm, 0mm, 5mm)
  Rectangle21.rotate(axis=X, angle=90deg)
  Rectangle21.rotate(axis=X, angle=180deg)
  Rectangle21.rotate(axis=X, angle=-270deg)
  Rectangle22 = rectangle(corner=(51.25mm, 68.75mm, 11.6mm), x_size=-1mm, y_size=-17.5mm)
  Rectangle22_1, Rectangle22_2 = Rectangle22.duplicate_along_line(step=(-0.25mm, -20mm, 0.4mm), total=3)
  Rectangle22_3, Rectangle22_4 = Rectangle22.duplicate_along_line(step=(-20mm, 0mm, 0mm), total=3)
  Rectangle22.move(-40mm, -40mm, 0mm)
  Rectangle22.move(0mm, 0mm, -6.6mm)
  Rectangle22.move(-40mm, 0mm, 3.4mm)
  Rectangle22.move(90mm, 0mm, -5mm)
  Rectangle22.move(1mm, -0.375mm, 2.2mm)
  Rectangle22.move(-49.5mm, 0.375mm, 4.4mm)
  Rectangle22.move(-1.5mm, 0mm, -10mm)
  Rectangle22.move(0mm, 0mm, 5mm)
  Rectangle22.rotate(axis=X, angle=90deg)
  Rectangle22.rotate(axis=X, angle=180deg)
  Rectangle22.rotate(axis=X, angle=-270deg)
  C3 = rectangle(corner=(59mm, 68.75mm, 11.6mm), x_size=0.5mm, y_size=1mm)
  C3_1, C3_2 = C3.duplicate_along_line(step=(-0.25mm, -20mm, 0.4mm), total=3)
  C3_3, C3_4 = C3.duplicate_along_line(step=(-20mm, 0mm, 0mm), total=3)
  C3.move(-40mm, -40mm, 0mm)
  C3.move(0mm, 0mm, -6.6mm)
  C3.move(-40mm, 0mm, 3.4mm)
  C3.move(90mm, 0mm, -5mm)
  C3.move(1mm, -0.375mm, 2.2mm)
  C3.move(-49.5mm, 0.375mm, 4.4mm)
  C3.move(-1.5mm, 0mm, -10mm)
  C3.move(0mm, 0mm, 5mm)
  C3.rotate(axis=X, angle=90deg)
  C3.rotate(axis=X, angle=180deg)
  C3.rotate(axis=X, angle=-270deg)
  C4 = rectangle(corner=(60.5mm, 68.75mm, 11.6mm), x_size=0.5mm, y_size=1mm)
  C4_1, C4_2 = C4.duplicate_along_line(step=(-0.25mm, -20mm, 0.4mm), total=3)
  C4_3, C4_4 = C4.duplicate_along_line(step=(-20mm, 0mm, 0mm), total=3)
  C4.move(-40mm, -40mm, 0mm)
  C4.move(0mm, 0mm, -6.6mm)
  C4.move(-40mm, 0mm, 3.4mm)
  C4.move(90mm, 0mm, -5mm)
  C4.move(1mm, -0.375mm, 2.2mm)
  C4.move(-49.5mm, 0.375mm, 4.4mm)
  C4.move(-1.5mm, 0mm, -10mm)
  C4.move(0mm, 0mm, 5mm)
  C4.rotate(axis=X, angle=90deg)
  C4.rotate(axis=X, angle=180deg)
  C4.rotate(axis=X, angle=-270deg)
  L1 = rectangle(corner=(59.5mm, 68.75mm, 11.6mm), x_size=0.5mm, y_size=1mm)
  L1_1, L1_2 = L1.duplicate_along_line(step=(-0.25mm, -20mm, 0.4mm), total=3)
  L1_3, L1_4 = L1.duplicate_along_line(step=(-20mm, 0mm, 0mm), total=3)
  L1.move(-40mm, -40mm, 0mm)
  L1.move(0mm, 0mm, -6.6mm)
  L1.move(-40mm, 0mm, 3.4mm)
  L1.move(90mm, 0mm, -5mm)
  L1.move(1mm, -0.375mm, 2.2mm)
  L1.move(-49.5mm, 0.375mm, 4.4mm)
  L1.move(-1.5mm, 0mm, -10mm)
  L1.move(0mm, 0mm, 5mm)
  L1.rotate(axis=X, angle=90deg)
  L1.rotate(axis=X, angle=180deg)
  L1.rotate(axis=X, angle=-270deg)
  R1 = rectangle(corner=(60mm, 68.75mm, 11.6mm), x_size=0.5mm, y_size=1mm)
  R1_1, R1_2 = R1.duplicate_along_line(step=(-0.25mm, -20mm, 0.4mm), total=3)
  R1_3, R1_4 = R1.duplicate_along_line(step=(-20mm, 0mm, 0mm), total=3)
  R1.move(-40mm, -40mm, 0mm)
  R1.move(0mm, 0mm, -6.6mm)
  R1.move(-40mm, 0mm, 3.4mm)
  R1.move(90mm, 0mm, -5mm)
  R1.move(1mm, -0.375mm, 2.2mm)
  R1.move(-49.5mm, 0.375mm, 4.4mm)
  R1.move(-1.5mm, 0mm, -10mm)
  R1.move(0mm, 0mm, 5mm)
  R1.rotate(axis=X, angle=90deg)
  R1.rotate(axis=X, angle=180deg)
  R1.rotate(axis=X, angle=-270deg)
  Rectangle1_1_1, Rectangle1_1_2 = Rectangle1_1.duplicate_along_line(step=(-20mm, 0mm, 0mm), total=3)
  Rectangle1_1.move(-40mm, -40mm, 0mm)
  Rectangle1_1.move(0mm, 0mm, -6.6mm)
  Rectangle1_1.move(-40mm, 0mm, 3.4mm)
  Rectangle1_1.move(90mm, 0mm, -5mm)
  Rectangle1_1.move(1mm, -0.375mm, 2.2mm)
  Rectangle1_1.move(-49.5mm, 0.375mm, 4.4mm)
  Rectangle1_1.move(-1.5mm, 0mm, -10mm)
  Rectangle1_1.move(0mm, 0mm, 5mm)
  Rectangle1_1.rotate(axis=X, angle=90deg)
  Rectangle1_1.rotate(axis=X, angle=180deg)
  Rectangle1_1.rotate(axis=X, angle=-270deg)
  Rectangle1_2_1, Rectangle1_2_2 = Rectangle1_2.duplicate_along_line(step=(-20mm, 0mm, 0mm), total=3)
  Rectangle1_2.move(-40mm, -40mm, 0mm)
  Rectangle1_2.move(0mm, 0mm, -6.6mm)
  Rectangle1_2.move(-40mm, 0mm, 3.4mm)
  Rectangle1_2.move(90mm, 0mm, -5mm)
  Rectangle1_2.move(1mm, -0.375mm, 2.2mm)
  Rectangle1_2.move(-49.5mm, 0.375mm, 4.4mm)
  Rectangle1_2.move(-1.5mm, 0mm, -10mm)
  Rectangle1_2.move(0mm, 0mm, 5mm)
  Rectangle1_2.rotate(axis=X, angle=90deg)
  Rectangle1_2.rotate(axis=X, angle=180deg)
  Rectangle1_2.rotate(axis=X, angle=-270deg)
  Rectangle2_1_1, Rectangle2_1_2 = Rectangle2_1.duplicate_along_line(step=(-20mm, 0mm, 0mm), total=3)
  Rectangle2_1.move(-40mm, -40mm, 0mm)
  Rectangle2_1.move(0mm, 0mm, -6.6mm)
  Rectangle2_1.move(-40mm, 0mm, 3.4mm)
  Rectangle2_1.move(90mm, 0mm, -5mm)
  Rectangle2_1.move(1mm, -0.375mm, 2.2mm)
  Rectangle2_1.move(-49.5mm, 0.375mm, 4.4mm)
  Rectangle2_1.move(-1.5mm, 0mm, -10mm)
  Rectangle2_1.move(0mm, 0mm, 5mm)
  Rectangle2_1.rotate(axis=X, angle=90deg)
  Rectangle2_1.rotate(axis=X, angle=180deg)
  Rectangle2_1.rotate(axis=X, angle=-270deg)
  Rectangle2_2_1, Rectangle2_2_2 = Rectangle2_2.duplicate_along_line(step=(-20mm, 0mm, 0mm), total=3)
  Rectangle2_2.move(-40mm, -40mm, 0mm)
  Rectangle2_2.move(0mm, 0mm, -6.6mm)
  Rectangle2_2.move(-40mm, 0mm, 3.4mm)
  Rectangle2_2.move(90mm, 0mm, -5mm)
  Rectangle2_2.move(1mm, -0.375mm, 2.2mm)
  Rectangle2_2.move(-49.5mm, 0.375mm, 4.4mm)
  Rectangle2_2.move(-1.5mm, 0mm, -10mm)
  Rectangle2_2.move(0mm, 0mm, 5mm)
  Rectangle2_2.rotate(axis=X, angle=90deg)
  Rectangle2_2.rotate(axis=X, angle=180deg)
  Rectangle2_2.rotate(axis=X, angle=-270deg)
  Rectangle21_1_1, Rectangle21_1_2 = Rectangle21_1.duplicate_along_line(step=(-20mm, 0mm, 0mm), total=3)
  Rectangle21_1.move(-40mm, -40mm, 0mm)
  Rectangle21_1.move(0mm, 0mm, -6.6mm)
  Rectangle21_1.move(-40mm, 0mm, 3.4mm)
  Rectangle21_1.move(90mm, 0mm, -5mm)
  Rectangle21_1.move(1mm, -0.375mm, 2.2mm)
  Rectangle21_1.move(-49.5mm, 0.375mm, 4.4mm)
  Rectangle21_1.move(-1.5mm, 0mm, -10mm)
  Rectangle21_1.move(0mm, 0mm, 5mm)
  Rectangle21_1.rotate(axis=X, angle=90deg)
  Rectangle21_1.rotate(axis=X, angle=180deg)
  Rectangle21_1.rotate(axis=X, angle=-270deg)
  Rectangle21_2_1, Rectangle21_2_2 = Rectangle21_2.duplicate_along_line(step=(-20mm, 0mm, 0mm), total=3)
  Rectangle21_2.move(-40mm, -40mm, 0mm)
  Rectangle21_2.move(0mm, 0mm, -6.6mm)
  Rectangle21_2.move(-40mm, 0mm, 3.4mm)
  Rectangle21_2.move(90mm, 0mm, -5mm)
  Rectangle21_2.move(1mm, -0.375mm, 2.2mm)
  Rectangle21_2.move(-49.5mm, 0.375mm, 4.4mm)
  Rectangle21_2.move(-1.5mm, 0mm, -10mm)
  Rectangle21_2.move(0mm, 0mm, 5mm)
  Rectangle21_2.rotate(axis=X, angle=90deg)
  Rectangle21_2.rotate(axis=X, angle=180deg)
  Rectangle21_2.rotate(axis=X, angle=-270deg)
  Rectangle22_1_1, Rectangle22_1_2 = Rectangle22_1.duplicate_along_line(step=(-20mm, 0mm, 0mm), total=3)
  Rectangle22_1.move(-40mm, -40mm, 0mm)
  Rectangle22_1.move(0mm, 0mm, -6.6mm)
  Rectangle22_1.move(-40mm, 0mm, 3.4mm)
  Rectangle22_1.move(90mm, 0mm, -5mm)
  Rectangle22_1.move(1mm, -0.375mm, 2.2mm)
  Rectangle22_1.move(-49.5mm, 0.375mm, 4.4mm)
  Rectangle22_1.move(-1.5mm, 0mm, -10mm)
  Rectangle22_1.move(0mm, 0mm, 5mm)
  Rectangle22_1.rotate(axis=X, angle=90deg)
  Rectangle22_1.rotate(axis=X, angle=180deg)
  Rectangle22_1.rotate(axis=X, angle=-270deg)
  Rectangle22_2_1, Rectangle22_2_2 = Rectangle22_2.duplicate_along_line(step=(-20mm, 0mm, 0mm), total=3)
  Rectangle22_2.move(-40mm, -40mm, 0mm)
  Rectangle22_2.move(0mm, 0mm, -6.6mm)
  Rectangle22_2.move(-40mm, 0mm, 3.4mm)
  Rectangle22_2.move(90mm, 0mm, -5mm)
  Rectangle22_2.move(1mm, -0.375mm, 2.2mm)
  Rectangle22_2.move(-49.5mm, 0.375mm, 4.4mm)
  Rectangle22_2.move(-1.5mm, 0mm, -10mm)
  Rectangle22_2.move(0mm, 0mm, 5mm)
  Rectangle22_2.rotate(axis=X, angle=90deg)
  Rectangle22_2.rotate(axis=X, angle=180deg)
  Rectangle22_2.rotate(axis=X, angle=-270deg)
  C1_1_1, C1_1_2 = C1_1.duplicate_along_line(step=(-20mm, 0mm, 0mm), total=3)
  C1_1.move(-40mm, -40mm, 0mm)
  C1_1.move(0mm, 0mm, -6.6mm)
  C1_1.move(-40mm, 0mm, 3.4mm)
  C1_1.move(90mm, 0mm, -5mm)
  C1_1.move(1mm, -0.375mm, 2.2mm)
  C1_1.move(-49.5mm, 0.375mm, 4.4mm)
  C1_1.move(-1.5mm, 0mm, -10mm)
  C1_1.move(0mm, 0mm, 5mm)
  C1_1.rotate(axis=X, angle=90deg)
  C1_1.rotate(axis=X, angle=180deg)
  C1_1.rotate(axis=X, angle=-270deg)
  C1_2_1, C1_2_2 = C1_2.duplicate_along_line(step=(-20mm, 0mm, 0mm), total=3)
  C1_2.move(-40mm, -40mm, 0mm)
  C1_2.move(0mm, 0mm, -6.6mm)
  C1_2.move(-40mm, 0mm, 3.4mm)
  C1_2.move(90mm, 0mm, -5mm)
  C1_2.move(1mm, -0.375mm, 2.2mm)
  C1_2.move(-49.5mm, 0.375mm, 4.4mm)
  C1_2.move(-1.5mm, 0mm, -10mm)
  C1_2.move(0mm, 0mm, 5mm)
  C1_2.rotate(axis=X, angle=90deg)
  C1_2.rotate(axis=X, angle=180deg)
  C1_2.rotate(axis=X, angle=-270deg)
  C2_1_1, C2_1_2 = C2_1.duplicate_along_line(step=(-20mm, 0mm, 0mm), total=3)
  C2_1.move(-40mm, -40mm, 0mm)
  C2_1.move(0mm, 0mm, -6.6mm)
  C2_1.move(-40mm, 0mm, 3.4mm)
  C2_1.move(90mm, 0mm, -5mm)
  C2_1.move(1mm, -0.375mm, 2.2mm)
  C2_1.move(-49.5mm, 0.375mm, 4.4mm)
  C2_1.move(-1.5mm, 0mm, -10mm)
  C2_1.move(0mm, 0mm, 5mm)
  C2_1.rotate(axis=X, angle=90deg)
  C2_1.rotate(axis=X, angle=180deg)
  C2_1.rotate(axis=X, angle=-270deg)
  C2_2_1, C2_2_2 = C2_2.duplicate_along_line(step=(-20mm, 0mm, 0mm), total=3)
  C2_2.move(-40mm, -40mm, 0mm)
  C2_2.move(0mm, 0mm, -6.6mm)
  C2_2.move(-40mm, 0mm, 3.4mm)
  C2_2.move(90mm, 0mm, -5mm)
  C2_2.move(1mm, -0.375mm, 2.2mm)
  C2_2.move(-49.5mm, 0.375mm, 4.4mm)
  C2_2.move(-1.5mm, 0mm, -10mm)
  C2_2.move(0mm, 0mm, 5mm)
  C2_2.rotate(axis=X, angle=90deg)
  C2_2.rotate(axis=X, angle=180deg)
  C2_2.rotate(axis=X, angle=-270deg)
  L_1_1, L_1_2 = L_1.duplicate_along_line(step=(-20mm, 0mm, 0mm), total=3)
  L_1.move(-40mm, -40mm, 0mm)
  L_1.move(0mm, 0mm, -6.6mm)
  L_1.move(-40mm, 0mm, 3.4mm)
  L_1.move(90mm, 0mm, -5mm)
  L_1.move(1mm, -0.375mm, 2.2mm)
  L_1.move(-49.5mm, 0.375mm, 4.4mm)
  L_1.move(-1.5mm, 0mm, -10mm)
  L_1.move(0mm, 0mm, 5mm)
  L_1.rotate(axis=X, angle=90deg)
  L_1.rotate(axis=X, angle=180deg)
  L_1.rotate(axis=X, angle=-270deg)
  L_2_1, L_2_2 = L_2.duplicate_along_line(step=(-20mm, 0mm, 0mm), total=3)
  L_2.move(-40mm, -40mm, 0mm)
  L_2.move(0mm, 0mm, -6.6mm)
  L_2.move(-40mm, 0mm, 3.4mm)
  L_2.move(90mm, 0mm, -5mm)
  L_2.move(1mm, -0.375mm, 2.2mm)
  L_2.move(-49.5mm, 0.375mm, 4.4mm)
  L_2.move(-1.5mm, 0mm, -10mm)
  L_2.move(0mm, 0mm, 5mm)
  L_2.rotate(axis=X, angle=90deg)
  L_2.rotate(axis=X, angle=180deg)
  L_2.rotate(axis=X, angle=-270deg)
  R_1_1, R_1_2 = R_1.duplicate_along_line(step=(-20mm, 0mm, 0mm), total=3)
  R_1.move(-40mm, -40mm, 0mm)
  R_1.move(0mm, 0mm, -6.6mm)
  R_1.move(-40mm, 0mm, 3.4mm)
  R_1.move(90mm, 0mm, -5mm)
  R_1.move(1mm, -0.375mm, 2.2mm)
  R_1.move(-49.5mm, 0.375mm, 4.4mm)
  R_1.move(-1.5mm, 0mm, -10mm)
  R_1.move(0mm, 0mm, 5mm)
  R_1.rotate(axis=X, angle=90deg)
  R_1.rotate(axis=X, angle=180deg)
  R_1.rotate(axis=X, angle=-270deg)
  R_2_1, R_2_2 = R_2.duplicate_along_line(step=(-20mm, 0mm, 0mm), total=3)
  R_2.move(-40mm, -40mm, 0mm)
  R_2.move(0mm, 0mm, -6.6mm)
  R_2.move(-40mm, 0mm, 3.4mm)
  R_2.move(90mm, 0mm, -5mm)
  R_2.move(1mm, -0.375mm, 2.2mm)
  R_2.move(-49.5mm, 0.375mm, 4.4mm)
  R_2.move(-1.5mm, 0mm, -10mm)
  R_2.move(0mm, 0mm, 5mm)
  R_2.rotate(axis=X, angle=90deg)
  R_2.rotate(axis=X, angle=180deg)
  R_2.rotate(axis=X, angle=-270deg)
  C3_1_1, C3_1_2 = C3_1.duplicate_along_line(step=(-20mm, 0mm, 0mm), total=3)
  C3_1.move(-40mm, -40mm, 0mm)
  C3_1.move(0mm, 0mm, -6.6mm)
  C3_1.move(-40mm, 0mm, 3.4mm)
  C3_1.move(90mm, 0mm, -5mm)
  C3_1.move(1mm, -0.375mm, 2.2mm)
  C3_1.move(-49.5mm, 0.375mm, 4.4mm)
  C3_1.move(-1.5mm, 0mm, -10mm)
  C3_1.move(0mm, 0mm, 5mm)
  C3_1.rotate(axis=X, angle=90deg)
  C3_1.rotate(axis=X, angle=180deg)
  C3_1.rotate(axis=X, angle=-270deg)
  C3_2_1, C3_2_2 = C3_2.duplicate_along_line(step=(-20mm, 0mm, 0mm), total=3)
  C3_2.move(-40mm, -40mm, 0mm)
  C3_2.move(0mm, 0mm, -6.6mm)
  C3_2.move(-40mm, 0mm, 3.4mm)
  C3_2.move(90mm, 0mm, -5mm)
  C3_2.move(1mm, -0.375mm, 2.2mm)
  C3_2.move(-49.5mm, 0.375mm, 4.4mm)
  C3_2.move(-1.5mm, 0mm, -10mm)
  C3_2.move(0mm, 0mm, 5mm)
  C3_2.rotate(axis=X, angle=90deg)
  C3_2.rotate(axis=X, angle=180deg)
  C3_2.rotate(axis=X, angle=-270deg)
  C4_1_1, C4_1_2 = C4_1.duplicate_along_line(step=(-20mm, 0mm, 0mm), total=3)
  C4_1.move(-40mm, -40mm, 0mm)
  C4_1.move(0mm, 0mm, -6.6mm)
  C4_1.move(-40mm, 0mm, 3.4mm)
  C4_1.move(90mm, 0mm, -5mm)
  C4_1.move(1mm, -0.375mm, 2.2mm)
  C4_1.move(-49.5mm, 0.375mm, 4.4mm)
  C4_1.move(-1.5mm, 0mm, -10mm)
  C4_1.move(0mm, 0mm, 5mm)
  C4_1.rotate(axis=X, angle=90deg)
  C4_1.rotate(axis=X, angle=180deg)
  C4_1.rotate(axis=X, angle=-270deg)
  C4_2_1, C4_2_2 = C4_2.duplicate_along_line(step=(-20mm, 0mm, 0mm), total=3)
  C4_2.move(-40mm, -40mm, 0mm)
  C4_2.move(0mm, 0mm, -6.6mm)
  C4_2.move(-40mm, 0mm, 3.4mm)
  C4_2.move(90mm, 0mm, -5mm)
  C4_2.move(1mm, -0.375mm, 2.2mm)
  C4_2.move(-49.5mm, 0.375mm, 4.4mm)
  C4_2.move(-1.5mm, 0mm, -10mm)
  C4_2.move(0mm, 0mm, 5mm)
  C4_2.rotate(axis=X, angle=90deg)
  C4_2.rotate(axis=X, angle=180deg)
  C4_2.rotate(axis=X, angle=-270deg)
  L1_1_1, L1_1_2 = L1_1.duplicate_along_line(step=(-20mm, 0mm, 0mm), total=3)
  L1_1.move(-40mm, -40mm, 0mm)
  L1_1.move(0mm, 0mm, -6.6mm)
  L1_1.move(-40mm, 0mm, 3.4mm)
  L1_1.move(90mm, 0mm, -5mm)
  L1_1.move(1mm, -0.375mm, 2.2mm)
  L1_1.move(-49.5mm, 0.375mm, 4.4mm)
  L1_1.move(-1.5mm, 0mm, -10mm)
  L1_1.move(0mm, 0mm, 5mm)
  L1_1.rotate(axis=X, angle=90deg)
  L1_1.rotate(axis=X, angle=180deg)
  L1_1.rotate(axis=X, angle=-270deg)
  L1_2_1, L1_2_2 = L1_2.duplicate_along_line(step=(-20mm, 0mm, 0mm), total=3)
  L1_2.move(-40mm, -40mm, 0mm)
  L1_2.move(0mm, 0mm, -6.6mm)
  L1_2.move(-40mm, 0mm, 3.4mm)
  L1_2.move(90mm, 0mm, -5mm)
  L1_2.move(1mm, -0.375mm, 2.2mm)
  L1_2.move(-49.5mm, 0.375mm, 4.4mm)
  L1_2.move(-1.5mm, 0mm, -10mm)
  L1_2.move(0mm, 0mm, 5mm)
  L1_2.rotate(axis=X, angle=90deg)
  L1_2.rotate(axis=X, angle=180deg)
  L1_2.rotate(axis=X, angle=-270deg)
  R1_1_1, R1_1_2 = R1_1.duplicate_along_line(step=(-20mm, 0mm, 0mm), total=3)
  R1_1.move(-40mm, -40mm, 0mm)
  R1_1.move(0mm, 0mm, -6.6mm)
  R1_1.move(-40mm, 0mm, 3.4mm)
  R1_1.move(90mm, 0mm, -5mm)
  R1_1.move(1mm, -0.375mm, 2.2mm)
  R1_1.move(-49.5mm, 0.375mm, 4.4mm)
  R1_1.move(-1.5mm, 0mm, -10mm)
  R1_1.move(0mm, 0mm, 5mm)
  R1_1.rotate(axis=X, angle=90deg)
  R1_1.rotate(axis=X, angle=180deg)
  R1_1.rotate(axis=X, angle=-270deg)
  R1_2_1, R1_2_2 = R1_2.duplicate_along_line(step=(-20mm, 0mm, 0mm), total=3)
  R1_2.move(-40mm, -40mm, 0mm)
  R1_2.move(0mm, 0mm, -6.6mm)
  R1_2.move(-40mm, 0mm, 3.4mm)
  R1_2.move(90mm, 0mm, -5mm)
  R1_2.move(1mm, -0.375mm, 2.2mm)
  R1_2.move(-49.5mm, 0.375mm, 4.4mm)
  R1_2.move(-1.5mm, 0mm, -10mm)
  R1_2.move(0mm, 0mm, 5mm)
  R1_2.rotate(axis=X, angle=90deg)
  R1_2.rotate(axis=X, angle=180deg)
  R1_2.rotate(axis=X, angle=-270deg)
  Rectangle1_3.move(-40mm, -40mm, 0mm)
  Rectangle1_3.move(0mm, 0mm, -6.6mm)
  Rectangle1_3.move(-40mm, 0mm, 3.4mm)
  Rectangle1_3.move(90mm, 0mm, -5mm)
  Rectangle1_3.move(1mm, -0.375mm, 2.2mm)
  Rectangle1_3.move(-49.5mm, 0.375mm, 4.4mm)
  Rectangle1_3.move(-1.5mm, 0mm, -10mm)
  Rectangle1_3.move(0mm, 0mm, 5mm)
  Rectangle1_3.rotate(axis=X, angle=90deg)
  Rectangle1_3.rotate(axis=X, angle=180deg)
  Rectangle1_3.rotate(axis=X, angle=-270deg)
  Rectangle1_4.move(-40mm, -40mm, 0mm)
  Rectangle1_4.move(0mm, 0mm, -6.6mm)
  Rectangle1_4.move(-40mm, 0mm, 3.4mm)
  Rectangle1_4.move(90mm, 0mm, -5mm)
  Rectangle1_4.move(1mm, -0.375mm, 2.2mm)
  Rectangle1_4.move(-49.5mm, 0.375mm, 4.4mm)
  Rectangle1_4.move(-1.5mm, 0mm, -10mm)
  Rectangle1_4.move(0mm, 0mm, 5mm)
  Rectangle1_4.rotate(axis=X, angle=90deg)
  Rectangle1_4.rotate(axis=X, angle=180deg)
  Rectangle1_4.rotate(axis=X, angle=-270deg)
  Rectangle2_3.move(-40mm, -40mm, 0mm)
  Rectangle2_3.move(0mm, 0mm, -6.6mm)
  Rectangle2_3.move(-40mm, 0mm, 3.4mm)
  Rectangle2_3.move(90mm, 0mm, -5mm)
  Rectangle2_3.move(1mm, -0.375mm, 2.2mm)
  Rectangle2_3.move(-49.5mm, 0.375mm, 4.4mm)
  Rectangle2_3.move(-1.5mm, 0mm, -10mm)
  Rectangle2_3.move(0mm, 0mm, 5mm)
  Rectangle2_3.rotate(axis=X, angle=90deg)
  Rectangle2_3.rotate(axis=X, angle=180deg)
  Rectangle2_3.rotate(axis=X, angle=-270deg)
  Rectangle2_4.move(-40mm, -40mm, 0mm)
  Rectangle2_4.move(0mm, 0mm, -6.6mm)
  Rectangle2_4.move(-40mm, 0mm, 3.4mm)
  Rectangle2_4.move(90mm, 0mm, -5mm)
  Rectangle2_4.move(1mm, -0.375mm, 2.2mm)
  Rectangle2_4.move(-49.5mm, 0.375mm, 4.4mm)
  Rectangle2_4.move(-1.5mm, 0mm, -10mm)
  Rectangle2_4.move(0mm, 0mm, 5mm)
  Rectangle2_4.rotate(axis=X, angle=90deg)
  Rectangle2_4.rotate(axis=X, angle=180deg)
  Rectangle2_4.rotate(axis=X, angle=-270deg)
  Rectangle21_3.move(-40mm, -40mm, 0mm)
  Rectangle21_3.move(0mm, 0mm, -6.6mm)
  Rectangle21_3.move(-40mm, 0mm, 3.4mm)
  Rectangle21_3.move(90mm, 0mm, -5mm)
  Rectangle21_3.move(1mm, -0.375mm, 2.2mm)
  Rectangle21_3.move(-49.5mm, 0.375mm, 4.4mm)
  Rectangle21_3.move(-1.5mm, 0mm, -10mm)
  Rectangle21_3.move(0mm, 0mm, 5mm)
  Rectangle21_3.rotate(axis=X, angle=90deg)
  Rectangle21_3.rotate(axis=X, angle=180deg)
  Rectangle21_3.rotate(axis=X, angle=-270deg)
  Rectangle21_4.move(-40mm, -40mm, 0mm)
  Rectangle21_4.move(0mm, 0mm, -6.6mm)
  Rectangle21_4.move(-40mm, 0mm, 3.4mm)
  Rectangle21_4.move(90mm, 0mm, -5mm)
  Rectangle21_4.move(1mm, -0.375mm, 2.2mm)
  Rectangle21_4.move(-49.5mm, 0.375mm, 4.4mm)
  Rectangle21_4.move(-1.5mm, 0mm, -10mm)
  Rectangle21_4.move(0mm, 0mm, 5mm)
  Rectangle21_4.rotate(axis=X, angle=90deg)
  Rectangle21_4.rotate(axis=X, angle=180deg)
  Rectangle21_4.rotate(axis=X, angle=-270deg)
  Rectangle22_3.move(-40mm, -40mm, 0mm)
  Rectangle22_3.move(0mm, 0mm, -6.6mm)
  Rectangle22_3.move(-40mm, 0mm, 3.4mm)
  Rectangle22_3.move(90mm, 0mm, -5mm)
  Rectangle22_3.move(1mm, -0.375mm, 2.2mm)
  Rectangle22_3.move(-49.5mm, 0.375mm, 4.4mm)
  Rectangle22_3.move(-1.5mm, 0mm, -10mm)
  Rectangle22_3.move(0mm, 0mm, 5mm)
  Rectangle22_3.rotate(axis=X, angle=90deg)
  Rectangle22_3.rotate(axis=X, angle=180deg)
  Rectangle22_3.rotate(axis=X, angle=-270deg)
  Rectangle22_4.move(-40mm, -40mm, 0mm)
  Rectangle22_4.move(0mm, 0mm, -6.6mm)
  Rectangle22_4.move(-40mm, 0mm, 3.4mm)
  Rectangle22_4.move(90mm, 0mm, -5mm)
  Rectangle22_4.move(1mm, -0.375mm, 2.2mm)
  Rectangle22_4.move(-49.5mm, 0.375mm, 4.4mm)
  Rectangle22_4.move(-1.5mm, 0mm, -10mm)
  Rectangle22_4.move(0mm, 0mm, 5mm)
  Rectangle22_4.rotate(axis=X, angle=90deg)
  Rectangle22_4.rotate(axis=X, angle=180deg)
  Rectangle22_4.rotate(axis=X, angle=-270deg)
  Rectangle1_1_1.move(-40mm, -40mm, 0mm)
  Rectangle1_1_1.move(0mm, 0mm, -6.6mm)
  Rectangle1_1_1.move(-40mm, 0mm, 3.4mm)
  Rectangle1_1_1.move(90mm, 0mm, -5mm)
  Rectangle1_1_1.move(1mm, -0.375mm, 2.2mm)
  Rectangle1_1_1.move(-49.5mm, 0.375mm, 4.4mm)
  Rectangle1_1_1.move(-1.5mm, 0mm, -10mm)
  Rectangle1_1_1.move(0mm, 0mm, 5mm)
  Rectangle1_1_1.rotate(axis=X, angle=90deg)
  Rectangle1_1_1.rotate(axis=X, angle=180deg)
  Rectangle1_1_1.rotate(axis=X, angle=-270deg)
  Rectangle1_1_2.move(-40mm, -40mm, 0mm)
  Rectangle1_1_2.move(0mm, 0mm, -6.6mm)
  Rectangle1_1_2.move(-40mm, 0mm, 3.4mm)
  Rectangle1_1_2.move(90mm, 0mm, -5mm)
  Rectangle1_1_2.move(1mm, -0.375mm, 2.2mm)
  Rectangle1_1_2.move(-49.5mm, 0.375mm, 4.4mm)
  Rectangle1_1_2.move(-1.5mm, 0mm, -10mm)
  Rectangle1_1_2.move(0mm, 0mm, 5mm)
  Rectangle1_1_2.rotate(axis=X, angle=90deg)
  Rectangle1_1_2.rotate(axis=X, angle=180deg)
  Rectangle1_1_2.rotate(axis=X, angle=-270deg)
  Rectangle1_2_1.move(-40mm, -40mm, 0mm)
  Rectangle1_2_1.move(0mm, 0mm, -6.6mm)
  Rectangle1_2_1.move(-40mm, 0mm, 3.4mm)
  Rectangle1_2_1.move(90mm, 0mm, -5mm)
  Rectangle1_2_1.move(1mm, -0.375mm, 2.2mm)
  Rectangle1_2_1.move(-49.5mm, 0.375mm, 4.4mm)
  Rectangle1_2_1.move(-1.5mm, 0mm, -10mm)
  Rectangle1_2_1.move(0mm, 0mm, 5mm)
  Rectangle1_2_1.rotate(axis=X, angle=90deg)
  Rectangle1_2_1.rotate(axis=X, angle=180deg)
  Rectangle1_2_1.rotate(axis=X, angle=-270deg)
  Rectangle1_2_2.move(-40mm, -40mm, 0mm)
  Rectangle1_2_2.move(0mm, 0mm, -6.6mm)
  Rectangle1_2_2.move(-40mm, 0mm, 3.4mm)
  Rectangle1_2_2.move(90mm, 0mm, -5mm)
  Rectangle1_2_2.move(1mm, -0.375mm, 2.2mm)
  Rectangle1_2_2.move(-49.5mm, 0.375mm, 4.4mm)
  Rectangle1_2_2.move(-1.5mm, 0mm, -10mm)
  Rectangle1_2_2.move(0mm, 0mm, 5mm)
  Rectangle1_2_2.rotate(axis=X, angle=90deg)
  Rectangle1_2_2.rotate(axis=X, angle=180deg)
  Rectangle1_2_2.rotate(axis=X, angle=-270deg)
  Rectangle2_1_1.move(-40mm, -40mm, 0mm)
  Rectangle2_1_1.move(0mm, 0mm, -6.6mm)
  Rectangle2_1_1.move(-40mm, 0mm, 3.4mm)
  Rectangle2_1_1.move(90mm, 0mm, -5mm)
  Rectangle2_1_1.move(1mm, -0.375mm, 2.2mm)
  Rectangle2_1_1.move(-49.5mm, 0.375mm, 4.4mm)
  Rectangle2_1_1.move(-1.5mm, 0mm, -10mm)
  Rectangle2_1_1.move(0mm, 0mm, 5mm)
  Rectangle2_1_1.rotate(axis=X, angle=90deg)
  Rectangle2_1_1.rotate(axis=X, angle=180deg)
  Rectangle2_1_1.rotate(axis=X, angle=-270deg)
  Rectangle2_1_2.move(-40mm, -40mm, 0mm)
  Rectangle2_1_2.move(0mm, 0mm, -6.6mm)
  Rectangle2_1_2.move(-40mm, 0mm, 3.4mm)
  Rectangle2_1_2.move(90mm, 0mm, -5mm)
  Rectangle2_1_2.move(1mm, -0.375mm, 2.2mm)
  Rectangle2_1_2.move(-49.5mm, 0.375mm, 4.4mm)
  Rectangle2_1_2.move(-1.5mm, 0mm, -10mm)
  Rectangle2_1_2.move(0mm, 0mm, 5mm)
  Rectangle2_1_2.rotate(axis=X, angle=90deg)
  Rectangle2_1_2.rotate(axis=X, angle=180deg)
  Rectangle2_1_2.rotate(axis=X, angle=-270deg)
  Rectangle2_2_1.move(-40mm, -40mm, 0mm)
  Rectangle2_2_1.move(0mm, 0mm, -6.6mm)
  Rectangle2_2_1.move(-40mm, 0mm, 3.4mm)
  Rectangle2_2_1.move(90mm, 0mm, -5mm)
  Rectangle2_2_1.move(1mm, -0.375mm, 2.2mm)
  Rectangle2_2_1.move(-49.5mm, 0.375mm, 4.4mm)
  Rectangle2_2_1.move(-1.5mm, 0mm, -10mm)
  Rectangle2_2_1.move(0mm, 0mm, 5mm)
  Rectangle2_2_1.rotate(axis=X, angle=90deg)
  Rectangle2_2_1.rotate(axis=X, angle=180deg)
  Rectangle2_2_1.rotate(axis=X, angle=-270deg)
  Rectangle2_2_2.move(-40mm, -40mm, 0mm)
  Rectangle2_2_2.move(0mm, 0mm, -6.6mm)
  Rectangle2_2_2.move(-40mm, 0mm, 3.4mm)
  Rectangle2_2_2.move(90mm, 0mm, -5mm)
  Rectangle2_2_2.move(1mm, -0.375mm, 2.2mm)
  Rectangle2_2_2.move(-49.5mm, 0.375mm, 4.4mm)
  Rectangle2_2_2.move(-1.5mm, 0mm, -10mm)
  Rectangle2_2_2.move(0mm, 0mm, 5mm)
  Rectangle2_2_2.rotate(axis=X, angle=90deg)
  Rectangle2_2_2.rotate(axis=X, angle=180deg)
  Rectangle2_2_2.rotate(axis=X, angle=-270deg)
  Rectangle21_1_1.move(-40mm, -40mm, 0mm)
  Rectangle21_1_1.move(0mm, 0mm, -6.6mm)
  Rectangle21_1_1.move(-40mm, 0mm, 3.4mm)
  Rectangle21_1_1.move(90mm, 0mm, -5mm)
  Rectangle21_1_1.move(1mm, -0.375mm, 2.2mm)
  Rectangle21_1_1.move(-49.5mm, 0.375mm, 4.4mm)
  Rectangle21_1_1.move(-1.5mm, 0mm, -10mm)
  Rectangle21_1_1.move(0mm, 0mm, 5mm)
  Rectangle21_1_1.rotate(axis=X, angle=90deg)
  Rectangle21_1_1.rotate(axis=X, angle=180deg)
  Rectangle21_1_1.rotate(axis=X, angle=-270deg)
  Rectangle21_1_2.move(-40mm, -40mm, 0mm)
  Rectangle21_1_2.move(0mm, 0mm, -6.6mm)
  Rectangle21_1_2.move(-40mm, 0mm, 3.4mm)
  Rectangle21_1_2.move(90mm, 0mm, -5mm)
  Rectangle21_1_2.move(1mm, -0.375mm, 2.2mm)
  Rectangle21_1_2.move(-49.5mm, 0.375mm, 4.4mm)
  Rectangle21_1_2.move(-1.5mm, 0mm, -10mm)
  Rectangle21_1_2.move(0mm, 0mm, 5mm)
  Rectangle21_1_2.rotate(axis=X, angle=90deg)
  Rectangle21_1_2.rotate(axis=X, angle=180deg)
  Rectangle21_1_2.rotate(axis=X, angle=-270deg)
  Rectangle21_2_1.move(-40mm, -40mm, 0mm)
  Rectangle21_2_1.move(0mm, 0mm, -6.6mm)
  Rectangle21_2_1.move(-40mm, 0mm, 3.4mm)
  Rectangle21_2_1.move(90mm, 0mm, -5mm)
  Rectangle21_2_1.move(1mm, -0.375mm, 2.2mm)
  Rectangle21_2_1.move(-49.5mm, 0.375mm, 4.4mm)
  Rectangle21_2_1.move(-1.5mm, 0mm, -10mm)
  Rectangle21_2_1.move(0mm, 0mm, 5mm)
  Rectangle21_2_1.rotate(axis=X, angle=90deg)
  Rectangle21_2_1.rotate(axis=X, angle=180deg)
  Rectangle21_2_1.rotate(axis=X, angle=-270deg)
  Rectangle21_2_2.move(-40mm, -40mm, 0mm)
  Rectangle21_2_2.move(0mm, 0mm, -6.6mm)
  Rectangle21_2_2.move(-40mm, 0mm, 3.4mm)
  Rectangle21_2_2.move(90mm, 0mm, -5mm)
  Rectangle21_2_2.move(1mm, -0.375mm, 2.2mm)
  Rectangle21_2_2.move(-49.5mm, 0.375mm, 4.4mm)
  Rectangle21_2_2.move(-1.5mm, 0mm, -10mm)
  Rectangle21_2_2.move(0mm, 0mm, 5mm)
  Rectangle21_2_2.rotate(axis=X, angle=90deg)
  Rectangle21_2_2.rotate(axis=X, angle=180deg)
  Rectangle21_2_2.rotate(axis=X, angle=-270deg)
  Rectangle22_1_1.move(-40mm, -40mm, 0mm)
  Rectangle22_1_1.move(0mm, 0mm, -6.6mm)
  Rectangle22_1_1.move(-40mm, 0mm, 3.4mm)
  Rectangle22_1_1.move(90mm, 0mm, -5mm)
  Rectangle22_1_1.move(1mm, -0.375mm, 2.2mm)
  Rectangle22_1_1.move(-49.5mm, 0.375mm, 4.4mm)
  Rectangle22_1_1.move(-1.5mm, 0mm, -10mm)
  Rectangle22_1_1.move(0mm, 0mm, 5mm)
  Rectangle22_1_1.rotate(axis=X, angle=90deg)
  Rectangle22_1_1.rotate(axis=X, angle=180deg)
  Rectangle22_1_1.rotate(axis=X, angle=-270deg)
  Rectangle22_1_2.move(-40mm, -40mm, 0mm)
  Rectangle22_1_2.move(0mm, 0mm, -6.6mm)
  Rectangle22_1_2.move(-40mm, 0mm, 3.4mm)
  Rectangle22_1_2.move(90mm, 0mm, -5mm)
  Rectangle22_1_2.move(1mm, -0.375mm, 2.2mm)
  Rectangle22_1_2.move(-49.5mm, 0.375mm, 4.4mm)
  Rectangle22_1_2.move(-1.5mm, 0mm, -10mm)
  Rectangle22_1_2.move(0mm, 0mm, 5mm)
  Rectangle22_1_2.rotate(axis=X, angle=90deg)
  Rectangle22_1_2.rotate(axis=X, angle=180deg)
  Rectangle22_1_2.rotate(axis=X, angle=-270deg)
  Rectangle22_2_1.move(-40mm, -40mm, 0mm)
  Rectangle22_2_1.move(0mm, 0mm, -6.6mm)
  Rectangle22_2_1.move(-40mm, 0mm, 3.4mm)
  Rectangle22_2_1.move(90mm, 0mm, -5mm)
  Rectangle22_2_1.move(1mm, -0.375mm, 2.2mm)
  Rectangle22_2_1.move(-49.5mm, 0.375mm, 4.4mm)
  Rectangle22_2_1.move(-1.5mm, 0mm, -10mm)
  Rectangle22_2_1.move(0mm, 0mm, 5mm)
  Rectangle22_2_1.rotate(axis=X, angle=90deg)
  Rectangle22_2_1.rotate(axis=X, angle=180deg)
  Rectangle22_2_1.rotate(axis=X, angle=-270deg)
  Rectangle22_2_2.move(-40mm, -40mm, 0mm)
  Rectangle22_2_2.move(0mm, 0mm, -6.6mm)
  Rectangle22_2_2.move(-40mm, 0mm, 3.4mm)
  Rectangle22_2_2.move(90mm, 0mm, -5mm)
  Rectangle22_2_2.move(1mm, -0.375mm, 2.2mm)
  Rectangle22_2_2.move(-49.5mm, 0.375mm, 4.4mm)
  Rectangle22_2_2.move(-1.5mm, 0mm, -10mm)
  Rectangle22_2_2.move(0mm, 0mm, 5mm)
  Rectangle22_2_2.rotate(axis=X, angle=90deg)
  Rectangle22_2_2.rotate(axis=X, angle=180deg)
  Rectangle22_2_2.rotate(axis=X, angle=-270deg)
  C1_3.move(-40mm, -40mm, 0mm)
  C1_3.move(0mm, 0mm, -6.6mm)
  C1_3.move(-40mm, 0mm, 3.4mm)
  C1_3.move(90mm, 0mm, -5mm)
  C1_3.move(1mm, -0.375mm, 2.2mm)
  C1_3.move(-49.5mm, 0.375mm, 4.4mm)
  C1_3.move(-1.5mm, 0mm, -10mm)
  C1_3.move(0mm, 0mm, 5mm)
  C1_3.rotate(axis=X, angle=90deg)
  C1_3.rotate(axis=X, angle=180deg)
  C1_3.rotate(axis=X, angle=-270deg)
  C1_4.move(-40mm, -40mm, 0mm)
  C1_4.move(0mm, 0mm, -6.6mm)
  C1_4.move(-40mm, 0mm, 3.4mm)
  C1_4.move(90mm, 0mm, -5mm)
  C1_4.move(1mm, -0.375mm, 2.2mm)
  C1_4.move(-49.5mm, 0.375mm, 4.4mm)
  C1_4.move(-1.5mm, 0mm, -10mm)
  C1_4.move(0mm, 0mm, 5mm)
  C1_4.rotate(axis=X, angle=90deg)
  C1_4.rotate(axis=X, angle=180deg)
  C1_4.rotate(axis=X, angle=-270deg)
  C2_3.move(-40mm, -40mm, 0mm)
  C2_3.move(0mm, 0mm, -6.6mm)
  C2_3.move(-40mm, 0mm, 3.4mm)
  C2_3.move(90mm, 0mm, -5mm)
  C2_3.move(1mm, -0.375mm, 2.2mm)
  C2_3.move(-49.5mm, 0.375mm, 4.4mm)
  C2_3.move(-1.5mm, 0mm, -10mm)
  C2_3.move(0mm, 0mm, 5mm)
  C2_3.rotate(axis=X, angle=90deg)
  C2_3.rotate(axis=X, angle=180deg)
  C2_3.rotate(axis=X, angle=-270deg)
  C2_4.move(-40mm, -40mm, 0mm)
  C2_4.move(0mm, 0mm, -6.6mm)
  C2_4.move(-40mm, 0mm, 3.4mm)
  C2_4.move(90mm, 0mm, -5mm)
  C2_4.move(1mm, -0.375mm, 2.2mm)
  C2_4.move(-49.5mm, 0.375mm, 4.4mm)
  C2_4.move(-1.5mm, 0mm, -10mm)
  C2_4.move(0mm, 0mm, 5mm)
  C2_4.rotate(axis=X, angle=90deg)
  C2_4.rotate(axis=X, angle=180deg)
  C2_4.rotate(axis=X, angle=-270deg)
  L_3.move(-40mm, -40mm, 0mm)
  L_3.move(0mm, 0mm, -6.6mm)
  L_3.move(-40mm, 0mm, 3.4mm)
  L_3.move(90mm, 0mm, -5mm)
  L_3.move(1mm, -0.375mm, 2.2mm)
  L_3.move(-49.5mm, 0.375mm, 4.4mm)
  L_3.move(-1.5mm, 0mm, -10mm)
  L_3.move(0mm, 0mm, 5mm)
  L_3.rotate(axis=X, angle=90deg)
  L_3.rotate(axis=X, angle=180deg)
  L_3.rotate(axis=X, angle=-270deg)
  L_4.move(-40mm, -40mm, 0mm)
  L_4.move(0mm, 0mm, -6.6mm)
  L_4.move(-40mm, 0mm, 3.4mm)
  L_4.move(90mm, 0mm, -5mm)
  L_4.move(1mm, -0.375mm, 2.2mm)
  L_4.move(-49.5mm, 0.375mm, 4.4mm)
  L_4.move(-1.5mm, 0mm, -10mm)
  L_4.move(0mm, 0mm, 5mm)
  L_4.rotate(axis=X, angle=90deg)
  L_4.rotate(axis=X, angle=180deg)
  L_4.rotate(axis=X, angle=-270deg)
  R_3.move(-40mm, -40mm, 0mm)
  R_3.move(0mm, 0mm, -6.6mm)
  R_3.move(-40mm, 0mm, 3.4mm)
  R_3.move(90mm, 0mm, -5mm)
  R_3.move(1mm, -0.375mm, 2.2mm)
  R_3.move(-49.5mm, 0.375mm, 4.4mm)
  R_3.move(-1.5mm, 0mm, -10mm)
  R_3.move(0mm, 0mm, 5mm)
  R_3.rotate(axis=X, angle=90deg)
  R_3.rotate(axis=X, angle=180deg)
  R_3.rotate(axis=X, angle=-270deg)
  R_4.move(-40mm, -40mm, 0mm)
  R_4.move(0mm, 0mm, -6.6mm)
  R_4.move(-40mm, 0mm, 3.4mm)
  R_4.move(90mm, 0mm, -5mm)
  R_4.move(1mm, -0.375mm, 2.2mm)
  R_4.move(-49.5mm, 0.375mm, 4.4mm)
  R_4.move(-1.5mm, 0mm, -10mm)
  R_4.move(0mm, 0mm, 5mm)
  R_4.rotate(axis=X, angle=90deg)
  R_4.rotate(axis=X, angle=180deg)
  R_4.rotate(axis=X, angle=-270deg)
  C1_1_1.move(-40mm, -40mm, 0mm)
  C1_1_1.move(0mm, 0mm, -6.6mm)
  C1_1_1.move(-40mm, 0mm, 3.4mm)
  C1_1_1.move(90mm, 0mm, -5mm)
  C1_1_1.move(1mm, -0.375mm, 2.2mm)
  C1_1_1.move(-49.5mm, 0.375mm, 4.4mm)
  C1_1_1.move(-1.5mm, 0mm, -10mm)
  C1_1_1.move(0mm, 0mm, 5mm)
  C1_1_1.rotate(axis=X, angle=90deg)
  C1_1_1.rotate(axis=X, angle=180deg)
  C1_1_1.rotate(axis=X, angle=-270deg)
  C1_1_2.move(-40mm, -40mm, 0mm)
  C1_1_2.move(0mm, 0mm, -6.6mm)
  C1_1_2.move(-40mm, 0mm, 3.4mm)
  C1_1_2.move(90mm, 0mm, -5mm)
  C1_1_2.move(1mm, -0.375mm, 2.2mm)
  C1_1_2.move(-49.5mm, 0.375mm, 4.4mm)
  C1_1_2.move(-1.5mm, 0mm, -10mm)
  C1_1_2.move(0mm, 0mm, 5mm)
  C1_1_2.rotate(axis=X, angle=90deg)
  C1_1_2.rotate(axis=X, angle=180deg)
  C1_1_2.rotate(axis=X, angle=-270deg)
  C1_2_1.move(-40mm, -40mm, 0mm)
  C1_2_1.move(0mm, 0mm, -6.6mm)
  C1_2_1.move(-40mm, 0mm, 3.4mm)
  C1_2_1.move(90mm, 0mm, -5mm)
  C1_2_1.move(1mm, -0.375mm, 2.2mm)
  C1_2_1.move(-49.5mm, 0.375mm, 4.4mm)
  C1_2_1.move(-1.5mm, 0mm, -10mm)
  C1_2_1.move(0mm, 0mm, 5mm)
  C1_2_1.rotate(axis=X, angle=90deg)
  C1_2_1.rotate(axis=X, angle=180deg)
  C1_2_1.rotate(axis=X, angle=-270deg)
  C1_2_2.move(-40mm, -40mm, 0mm)
  C1_2_2.move(0mm, 0mm, -6.6mm)
  C1_2_2.move(-40mm, 0mm, 3.4mm)
  C1_2_2.move(90mm, 0mm, -5mm)
  C1_2_2.move(1mm, -0.375mm, 2.2mm)
  C1_2_2.move(-49.5mm, 0.375mm, 4.4mm)
  C1_2_2.move(-1.5mm, 0mm, -10mm)
  C1_2_2.move(0mm, 0mm, 5mm)
  C1_2_2.rotate(axis=X, angle=90deg)
  C1_2_2.rotate(axis=X, angle=180deg)
  C1_2_2.rotate(axis=X, angle=-270deg)
  C2_1_1.move(-40mm, -40mm, 0mm)
  C2_1_1.move(0mm, 0mm, -6.6mm)
  C2_1_1.move(-40mm, 0mm, 3.4mm)
  C2_1_1.move(90mm, 0mm, -5mm)
  C2_1_1.move(1mm, -0.375mm, 2.2mm)
  C2_1_1.move(-49.5mm, 0.375mm, 4.4mm)
  C2_1_1.move(-1.5mm, 0mm, -10mm)
  C2_1_1.move(0mm, 0mm, 5mm)
  C2_1_1.rotate(axis=X, angle=90deg)
  C2_1_1.rotate(axis=X, angle=180deg)
  C2_1_1.rotate(axis=X, angle=-270deg)
  C2_1_2.move(-40mm, -40mm, 0mm)
  C2_1_2.move(0mm, 0mm, -6.6mm)
  C2_1_2.move(-40mm, 0mm, 3.4mm)
  C2_1_2.move(90mm, 0mm, -5mm)
  C2_1_2.move(1mm, -0.375mm, 2.2mm)
  C2_1_2.move(-49.5mm, 0.375mm, 4.4mm)
  C2_1_2.move(-1.5mm, 0mm, -10mm)
  C2_1_2.move(0mm, 0mm, 5mm)
  C2_1_2.rotate(axis=X, angle=90deg)
  C2_1_2.rotate(axis=X, angle=180deg)
  C2_1_2.rotate(axis=X, angle=-270deg)
  C2_2_1.move(-40mm, -40mm, 0mm)
  C2_2_1.move(0mm, 0mm, -6.6mm)
  C2_2_1.move(-40mm, 0mm, 3.4mm)
  C2_2_1.move(90mm, 0mm, -5mm)
  C2_2_1.move(1mm, -0.375mm, 2.2mm)
  C2_2_1.move(-49.5mm, 0.375mm, 4.4mm)
  C2_2_1.move(-1.5mm, 0mm, -10mm)
  C2_2_1.move(0mm, 0mm, 5mm)
  C2_2_1.rotate(axis=X, angle=90deg)
  C2_2_1.rotate(axis=X, angle=180deg)
  C2_2_1.rotate(axis=X, angle=-270deg)
  C2_2_2.move(-40mm, -40mm, 0mm)
  C2_2_2.move(0mm, 0mm, -6.6mm)
  C2_2_2.move(-40mm, 0mm, 3.4mm)
  C2_2_2.move(90mm, 0mm, -5mm)
  C2_2_2.move(1mm, -0.375mm, 2.2mm)
  C2_2_2.move(-49.5mm, 0.375mm, 4.4mm)
  C2_2_2.move(-1.5mm, 0mm, -10mm)
  C2_2_2.move(0mm, 0mm, 5mm)
  C2_2_2.rotate(axis=X, angle=90deg)
  C2_2_2.rotate(axis=X, angle=180deg)
  C2_2_2.rotate(axis=X, angle=-270deg)
  L_1_1.move(-40mm, -40mm, 0mm)
  L_1_1.move(0mm, 0mm, -6.6mm)
  L_1_1.move(-40mm, 0mm, 3.4mm)
  L_1_1.move(90mm, 0mm, -5mm)
  L_1_1.move(1mm, -0.375mm, 2.2mm)
  L_1_1.move(-49.5mm, 0.375mm, 4.4mm)
  L_1_1.move(-1.5mm, 0mm, -10mm)
  L_1_1.move(0mm, 0mm, 5mm)
  L_1_1.rotate(axis=X, angle=90deg)
  L_1_1.rotate(axis=X, angle=180deg)
  L_1_1.rotate(axis=X, angle=-270deg)
  L_1_2.move(-40mm, -40mm, 0mm)
  L_1_2.move(0mm, 0mm, -6.6mm)
  L_1_2.move(-40mm, 0mm, 3.4mm)
  L_1_2.move(90mm, 0mm, -5mm)
  L_1_2.move(1mm, -0.375mm, 2.2mm)
  L_1_2.move(-49.5mm, 0.375mm, 4.4mm)
  L_1_2.move(-1.5mm, 0mm, -10mm)
  L_1_2.move(0mm, 0mm, 5mm)
  L_1_2.rotate(axis=X, angle=90deg)
  L_1_2.rotate(axis=X, angle=180deg)
  L_1_2.rotate(axis=X, angle=-270deg)
  L_2_1.move(-40mm, -40mm, 0mm)
  L_2_1.move(0mm, 0mm, -6.6mm)
  L_2_1.move(-40mm, 0mm, 3.4mm)
  L_2_1.move(90mm, 0mm, -5mm)
  L_2_1.move(1mm, -0.375mm, 2.2mm)
  L_2_1.move(-49.5mm, 0.375mm, 4.4mm)
  L_2_1.move(-1.5mm, 0mm, -10mm)
  L_2_1.move(0mm, 0mm, 5mm)
  L_2_1.rotate(axis=X, angle=90deg)
  L_2_1.rotate(axis=X, angle=180deg)
  L_2_1.rotate(axis=X, angle=-270deg)
  L_2_2.move(-40mm, -40mm, 0mm)
  L_2_2.move(0mm, 0mm, -6.6mm)
  L_2_2.move(-40mm, 0mm, 3.4mm)
  L_2_2.move(90mm, 0mm, -5mm)
  L_2_2.move(1mm, -0.375mm, 2.2mm)
  L_2_2.move(-49.5mm, 0.375mm, 4.4mm)
  L_2_2.move(-1.5mm, 0mm, -10mm)
  L_2_2.move(0mm, 0mm, 5mm)
  L_2_2.rotate(axis=X, angle=90deg)
  L_2_2.rotate(axis=X, angle=180deg)
  L_2_2.rotate(axis=X, angle=-270deg)
  R_1_1.move(-40mm, -40mm, 0mm)
  R_1_1.move(0mm, 0mm, -6.6mm)
  R_1_1.move(-40mm, 0mm, 3.4mm)
  R_1_1.move(90mm, 0mm, -5mm)
  R_1_1.move(1mm, -0.375mm, 2.2mm)
  R_1_1.move(-49.5mm, 0.375mm, 4.4mm)
  R_1_1.move(-1.5mm, 0mm, -10mm)
  R_1_1.move(0mm, 0mm, 5mm)
  R_1_1.rotate(axis=X, angle=90deg)
  R_1_1.rotate(axis=X, angle=180deg)
  R_1_1.rotate(axis=X, angle=-270deg)
  R_1_2.move(-40mm, -40mm, 0mm)
  R_1_2.move(0mm, 0mm, -6.6mm)
  R_1_2.move(-40mm, 0mm, 3.4mm)
  R_1_2.move(90mm, 0mm, -5mm)
  R_1_2.move(1mm, -0.375mm, 2.2mm)
  R_1_2.move(-49.5mm, 0.375mm, 4.4mm)
  R_1_2.move(-1.5mm, 0mm, -10mm)
  R_1_2.move(0mm, 0mm, 5mm)
  R_1_2.rotate(axis=X, angle=90deg)
  R_1_2.rotate(axis=X, angle=180deg)
  R_1_2.rotate(axis=X, angle=-270deg)
  R_2_1.move(-40mm, -40mm, 0mm)
  R_2_1.move(0mm, 0mm, -6.6mm)
  R_2_1.move(-40mm, 0mm, 3.4mm)
  R_2_1.move(90mm, 0mm, -5mm)
  R_2_1.move(1mm, -0.375mm, 2.2mm)
  R_2_1.move(-49.5mm, 0.375mm, 4.4mm)
  R_2_1.move(-1.5mm, 0mm, -10mm)
  R_2_1.move(0mm, 0mm, 5mm)
  R_2_1.rotate(axis=X, angle=90deg)
  R_2_1.rotate(axis=X, angle=180deg)
  R_2_1.rotate(axis=X, angle=-270deg)
  R_2_2.move(-40mm, -40mm, 0mm)
  R_2_2.move(0mm, 0mm, -6.6mm)
  R_2_2.move(-40mm, 0mm, 3.4mm)
  R_2_2.move(90mm, 0mm, -5mm)
  R_2_2.move(1mm, -0.375mm, 2.2mm)
  R_2_2.move(-49.5mm, 0.375mm, 4.4mm)
  R_2_2.move(-1.5mm, 0mm, -10mm)
  R_2_2.move(0mm, 0mm, 5mm)
  R_2_2.rotate(axis=X, angle=90deg)
  R_2_2.rotate(axis=X, angle=180deg)
  R_2_2.rotate(axis=X, angle=-270deg)
  C3_3.move(-40mm, -40mm, 0mm)
  C3_3.move(0mm, 0mm, -6.6mm)
  C3_3.move(-40mm, 0mm, 3.4mm)
  C3_3.move(90mm, 0mm, -5mm)
  C3_3.move(1mm, -0.375mm, 2.2mm)
  C3_3.move(-49.5mm, 0.375mm, 4.4mm)
  C3_3.move(-1.5mm, 0mm, -10mm)
  C3_3.move(0mm, 0mm, 5mm)
  C3_3.rotate(axis=X, angle=90deg)
  C3_3.rotate(axis=X, angle=180deg)
  C3_3.rotate(axis=X, angle=-270deg)
  C3_4.move(-40mm, -40mm, 0mm)
  C3_4.move(0mm, 0mm, -6.6mm)
  C3_4.move(-40mm, 0mm, 3.4mm)
  C3_4.move(90mm, 0mm, -5mm)
  C3_4.move(1mm, -0.375mm, 2.2mm)
  C3_4.move(-49.5mm, 0.375mm, 4.4mm)
  C3_4.move(-1.5mm, 0mm, -10mm)
  C3_4.move(0mm, 0mm, 5mm)
  C3_4.rotate(axis=X, angle=90deg)
  C3_4.rotate(axis=X, angle=180deg)
  C3_4.rotate(axis=X, angle=-270deg)
  C4_3.move(-40mm, -40mm, 0mm)
  C4_3.move(0mm, 0mm, -6.6mm)
  C4_3.move(-40mm, 0mm, 3.4mm)
  C4_3.move(90mm, 0mm, -5mm)
  C4_3.move(1mm, -0.375mm, 2.2mm)
  C4_3.move(-49.5mm, 0.375mm, 4.4mm)
  C4_3.move(-1.5mm, 0mm, -10mm)
  C4_3.move(0mm, 0mm, 5mm)
  C4_3.rotate(axis=X, angle=90deg)
  C4_3.rotate(axis=X, angle=180deg)
  C4_3.rotate(axis=X, angle=-270deg)
  C4_4.move(-40mm, -40mm, 0mm)
  C4_4.move(0mm, 0mm, -6.6mm)
  C4_4.move(-40mm, 0mm, 3.4mm)
  C4_4.move(90mm, 0mm, -5mm)
  C4_4.move(1mm, -0.375mm, 2.2mm)
  C4_4.move(-49.5mm, 0.375mm, 4.4mm)
  C4_4.move(-1.5mm, 0mm, -10mm)
  C4_4.move(0mm, 0mm, 5mm)
  C4_4.rotate(axis=X, angle=90deg)
  C4_4.rotate(axis=X, angle=180deg)
  C4_4.rotate(axis=X, angle=-270deg)
  L1_3.move(-40mm, -40mm, 0mm)
  L1_3.move(0mm, 0mm, -6.6mm)
  L1_3.move(-40mm, 0mm, 3.4mm)
  L1_3.move(90mm, 0mm, -5mm)
  L1_3.move(1mm, -0.375mm, 2.2mm)
  L1_3.move(-49.5mm, 0.375mm, 4.4mm)
  L1_3.move(-1.5mm, 0mm, -10mm)
  L1_3.move(0mm, 0mm, 5mm)
  L1_3.rotate(axis=X, angle=90deg)
  L1_3.rotate(axis=X, angle=180deg)
  L1_3.rotate(axis=X, angle=-270deg)
  L1_4.move(-40mm, -40mm, 0mm)
  L1_4.move(0mm, 0mm, -6.6mm)
  L1_4.move(-40mm, 0mm, 3.4mm)
  L1_4.move(90mm, 0mm, -5mm)
  L1_4.move(1mm, -0.375mm, 2.2mm)
  L1_4.move(-49.5mm, 0.375mm, 4.4mm)
  L1_4.move(-1.5mm, 0mm, -10mm)
  L1_4.move(0mm, 0mm, 5mm)
  L1_4.rotate(axis=X, angle=90deg)
  L1_4.rotate(axis=X, angle=180deg)
  L1_4.rotate(axis=X, angle=-270deg)
  R1_3.move(-40mm, -40mm, 0mm)
  R1_3.move(0mm, 0mm, -6.6mm)
  R1_3.move(-40mm, 0mm, 3.4mm)
  R1_3.move(90mm, 0mm, -5mm)
  R1_3.move(1mm, -0.375mm, 2.2mm)
  R1_3.move(-49.5mm, 0.375mm, 4.4mm)
  R1_3.move(-1.5mm, 0mm, -10mm)
  R1_3.move(0mm, 0mm, 5mm)
  R1_3.rotate(axis=X, angle=90deg)
  R1_3.rotate(axis=X, angle=180deg)
  R1_3.rotate(axis=X, angle=-270deg)
  R1_4.move(-40mm, -40mm, 0mm)
  R1_4.move(0mm, 0mm, -6.6mm)
  R1_4.move(-40mm, 0mm, 3.4mm)
  R1_4.move(90mm, 0mm, -5mm)
  R1_4.move(1mm, -0.375mm, 2.2mm)
  R1_4.move(-49.5mm, 0.375mm, 4.4mm)
  R1_4.move(-1.5mm, 0mm, -10mm)
  R1_4.move(0mm, 0mm, 5mm)
  R1_4.rotate(axis=X, angle=90deg)
  R1_4.rotate(axis=X, angle=180deg)
  R1_4.rotate(axis=X, angle=-270deg)
  C3_1_1.move(-40mm, -40mm, 0mm)
  C3_1_1.move(0mm, 0mm, -6.6mm)
  C3_1_1.move(-40mm, 0mm, 3.4mm)
  C3_1_1.move(90mm, 0mm, -5mm)
  C3_1_1.move(1mm, -0.375mm, 2.2mm)
  C3_1_1.move(-49.5mm, 0.375mm, 4.4mm)
  C3_1_1.move(-1.5mm, 0mm, -10mm)
  C3_1_1.move(0mm, 0mm, 5mm)
  C3_1_1.rotate(axis=X, angle=90deg)
  C3_1_1.rotate(axis=X, angle=180deg)
  C3_1_1.rotate(axis=X, angle=-270deg)
  C3_1_2.move(-40mm, -40mm, 0mm)
  C3_1_2.move(0mm, 0mm, -6.6mm)
  C3_1_2.move(-40mm, 0mm, 3.4mm)
  C3_1_2.move(90mm, 0mm, -5mm)
  C3_1_2.move(1mm, -0.375mm, 2.2mm)
  C3_1_2.move(-49.5mm, 0.375mm, 4.4mm)
  C3_1_2.move(-1.5mm, 0mm, -10mm)
  C3_1_2.move(0mm, 0mm, 5mm)
  C3_1_2.rotate(axis=X, angle=90deg)
  C3_1_2.rotate(axis=X, angle=180deg)
  C3_1_2.rotate(axis=X, angle=-270deg)
  C3_2_1.move(-40mm, -40mm, 0mm)
  C3_2_1.move(0mm, 0mm, -6.6mm)
  C3_2_1.move(-40mm, 0mm, 3.4mm)
  C3_2_1.move(90mm, 0mm, -5mm)
  C3_2_1.move(1mm, -0.375mm, 2.2mm)
  C3_2_1.move(-49.5mm, 0.375mm, 4.4mm)
  C3_2_1.move(-1.5mm, 0mm, -10mm)
  C3_2_1.move(0mm, 0mm, 5mm)
  C3_2_1.rotate(axis=X, angle=90deg)
  C3_2_1.rotate(axis=X, angle=180deg)
  C3_2_1.rotate(axis=X, angle=-270deg)
  C3_2_2.move(-40mm, -40mm, 0mm)
  C3_2_2.move(0mm, 0mm, -6.6mm)
  C3_2_2.move(-40mm, 0mm, 3.4mm)
  C3_2_2.move(90mm, 0mm, -5mm)
  C3_2_2.move(1mm, -0.375mm, 2.2mm)
  C3_2_2.move(-49.5mm, 0.375mm, 4.4mm)
  C3_2_2.move(-1.5mm, 0mm, -10mm)
  C3_2_2.move(0mm, 0mm, 5mm)
  C3_2_2.rotate(axis=X, angle=90deg)
  C3_2_2.rotate(axis=X, angle=180deg)
  C3_2_2.rotate(axis=X, angle=-270deg)
  C4_1_1.move(-40mm, -40mm, 0mm)
  C4_1_1.move(0mm, 0mm, -6.6mm)
  C4_1_1.move(-40mm, 0mm, 3.4mm)
  C4_1_1.move(90mm, 0mm, -5mm)
  C4_1_1.move(1mm, -0.375mm, 2.2mm)
  C4_1_1.move(-49.5mm, 0.375mm, 4.4mm)
  C4_1_1.move(-1.5mm, 0mm, -10mm)
  C4_1_1.move(0mm, 0mm, 5mm)
  C4_1_1.rotate(axis=X, angle=90deg)
  C4_1_1.rotate(axis=X, angle=180deg)
  C4_1_1.rotate(axis=X, angle=-270deg)
  C4_1_2.move(-40mm, -40mm, 0mm)
  C4_1_2.move(0mm, 0mm, -6.6mm)
  C4_1_2.move(-40mm, 0mm, 3.4mm)
  C4_1_2.move(90mm, 0mm, -5mm)
  C4_1_2.move(1mm, -0.375mm, 2.2mm)
  C4_1_2.move(-49.5mm, 0.375mm, 4.4mm)
  C4_1_2.move(-1.5mm, 0mm, -10mm)
  C4_1_2.move(0mm, 0mm, 5mm)
  C4_1_2.rotate(axis=X, angle=90deg)
  C4_1_2.rotate(axis=X, angle=180deg)
  C4_1_2.rotate(axis=X, angle=-270deg)
  C4_2_1.move(-40mm, -40mm, 0mm)
  C4_2_1.move(0mm, 0mm, -6.6mm)
  C4_2_1.move(-40mm, 0mm, 3.4mm)
  C4_2_1.move(90mm, 0mm, -5mm)
  C4_2_1.move(1mm, -0.375mm, 2.2mm)
  C4_2_1.move(-49.5mm, 0.375mm, 4.4mm)
  C4_2_1.move(-1.5mm, 0mm, -10mm)
  C4_2_1.move(0mm, 0mm, 5mm)
  C4_2_1.rotate(axis=X, angle=90deg)
  C4_2_1.rotate(axis=X, angle=180deg)
  C4_2_1.rotate(axis=X, angle=-270deg)
  C4_2_2.move(-40mm, -40mm, 0mm)
  C4_2_2.move(0mm, 0mm, -6.6mm)
  C4_2_2.move(-40mm, 0mm, 3.4mm)
  C4_2_2.move(90mm, 0mm, -5mm)
  C4_2_2.move(1mm, -0.375mm, 2.2mm)
  C4_2_2.move(-49.5mm, 0.375mm, 4.4mm)
  C4_2_2.move(-1.5mm, 0mm, -10mm)
  C4_2_2.move(0mm, 0mm, 5mm)
  C4_2_2.rotate(axis=X, angle=90deg)
  C4_2_2.rotate(axis=X, angle=180deg)
  C4_2_2.rotate(axis=X, angle=-270deg)
  L1_1_1.move(-40mm, -40mm, 0mm)
  L1_1_1.move(0mm, 0mm, -6.6mm)
  L1_1_1.move(-40mm, 0mm, 3.4mm)
  L1_1_1.move(90mm, 0mm, -5mm)
  L1_1_1.move(1mm, -0.375mm, 2.2mm)
  L1_1_1.move(-49.5mm, 0.375mm, 4.4mm)
  L1_1_1.move(-1.5mm, 0mm, -10mm)
  L1_1_1.move(0mm, 0mm, 5mm)
  L1_1_1.rotate(axis=X, angle=90deg)
  L1_1_1.rotate(axis=X, angle=180deg)
  L1_1_1.rotate(axis=X, angle=-270deg)
  L1_1_2.move(-40mm, -40mm, 0mm)
  L1_1_2.move(0mm, 0mm, -6.6mm)
  L1_1_2.move(-40mm, 0mm, 3.4mm)
  L1_1_2.move(90mm, 0mm, -5mm)
  L1_1_2.move(1mm, -0.375mm, 2.2mm)
  L1_1_2.move(-49.5mm, 0.375mm, 4.4mm)
  L1_1_2.move(-1.5mm, 0mm, -10mm)
  L1_1_2.move(0mm, 0mm, 5mm)
  L1_1_2.rotate(axis=X, angle=90deg)
  L1_1_2.rotate(axis=X, angle=180deg)
  L1_1_2.rotate(axis=X, angle=-270deg)
  L1_2_1.move(-40mm, -40mm, 0mm)
  L1_2_1.move(0mm, 0mm, -6.6mm)
  L1_2_1.move(-40mm, 0mm, 3.4mm)
  L1_2_1.move(90mm, 0mm, -5mm)
  L1_2_1.move(1mm, -0.375mm, 2.2mm)
  L1_2_1.move(-49.5mm, 0.375mm, 4.4mm)
  L1_2_1.move(-1.5mm, 0mm, -10mm)
  L1_2_1.move(0mm, 0mm, 5mm)
  L1_2_1.rotate(axis=X, angle=90deg)
  L1_2_1.rotate(axis=X, angle=180deg)
  L1_2_1.rotate(axis=X, angle=-270deg)
  L1_2_2.move(-40mm, -40mm, 0mm)
  L1_2_2.move(0mm, 0mm, -6.6mm)
  L1_2_2.move(-40mm, 0mm, 3.4mm)
  L1_2_2.move(90mm, 0mm, -5mm)
  L1_2_2.move(1mm, -0.375mm, 2.2mm)
  L1_2_2.move(-49.5mm, 0.375mm, 4.4mm)
  L1_2_2.move(-1.5mm, 0mm, -10mm)
  L1_2_2.move(0mm, 0mm, 5mm)
  L1_2_2.rotate(axis=X, angle=90deg)
  L1_2_2.rotate(axis=X, angle=180deg)
  L1_2_2.rotate(axis=X, angle=-270deg)
  R1_1_1.move(-40mm, -40mm, 0mm)
  R1_1_1.move(0mm, 0mm, -6.6mm)
  R1_1_1.move(-40mm, 0mm, 3.4mm)
  R1_1_1.move(90mm, 0mm, -5mm)
  R1_1_1.move(1mm, -0.375mm, 2.2mm)
  R1_1_1.move(-49.5mm, 0.375mm, 4.4mm)
  R1_1_1.move(-1.5mm, 0mm, -10mm)
  R1_1_1.move(0mm, 0mm, 5mm)
  R1_1_1.rotate(axis=X, angle=90deg)
  R1_1_1.rotate(axis=X, angle=180deg)
  R1_1_1.rotate(axis=X, angle=-270deg)
  R1_1_2.move(-40mm, -40mm, 0mm)
  R1_1_2.move(0mm, 0mm, -6.6mm)
  R1_1_2.move(-40mm, 0mm, 3.4mm)
  R1_1_2.move(90mm, 0mm, -5mm)
  R1_1_2.move(1mm, -0.375mm, 2.2mm)
  R1_1_2.move(-49.5mm, 0.375mm, 4.4mm)
  R1_1_2.move(-1.5mm, 0mm, -10mm)
  R1_1_2.move(0mm, 0mm, 5mm)
  R1_1_2.rotate(axis=X, angle=90deg)
  R1_1_2.rotate(axis=X, angle=180deg)
  R1_1_2.rotate(axis=X, angle=-270deg)
  R1_2_1.move(-40mm, -40mm, 0mm)
  R1_2_1.move(0mm, 0mm, -6.6mm)
  R1_2_1.move(-40mm, 0mm, 3.4mm)
  R1_2_1.move(90mm, 0mm, -5mm)
  R1_2_1.move(1mm, -0.375mm, 2.2mm)
  R1_2_1.move(-49.5mm, 0.375mm, 4.4mm)
  R1_2_1.move(-1.5mm, 0mm, -10mm)
  R1_2_1.move(0mm, 0mm, 5mm)
  R1_2_1.rotate(axis=X, angle=90deg)
  R1_2_1.rotate(axis=X, angle=180deg)
  R1_2_1.rotate(axis=X, angle=-270deg)
  R1_2_2.move(-40mm, -40mm, 0mm)
  R1_2_2.move(0mm, 0mm, -6.6mm)
  R1_2_2.move(-40mm, 0mm, 3.4mm)
  R1_2_2.move(90mm, 0mm, -5mm)
  R1_2_2.move(1mm, -0.375mm, 2.2mm)
  R1_2_2.move(-49.5mm, 0.375mm, 4.4mm)
  R1_2_2.move(-1.5mm, 0mm, -10mm)
  R1_2_2.move(0mm, 0mm, 5mm)
  R1_2_2.rotate(axis=X, angle=90deg)
  R1_2_2.rotate(axis=X, angle=180deg)
  R1_2_2.rotate(axis=X, angle=-270deg)
  [Rectangle9..Rectangle16].move(0mm, -10mm, 0mm)
  subs.move(0mm, -20mm, 0mm)
  subs.move(0mm, 10mm, 0mm)
  [subs, Port, Rectangle9..Rectangle16].move(0mm, 0mm, -6.6mm)
  group topface = Rectangle9..Rectangle12
  group bottomface = Rectangle13..Rectangle16
  group Group1 = C1, C2, L, R, C1_1, C1_2, C2_1, C2_2, L_1, L_2, R_1, R_2, C1_3, C1_4, C2_3, C2_4, L_3, L_4, R_3, R_4, C1_1_1, C1_1_2, C1_2_1, C1_2_2, C2_1_1, C2_1_2, C2_2_1, C2_2_2, L_1_1, L_1_2, L_2_1, L_2_2, R_1_1, R_1_2, R_2_1, R_2_2
  group Group2 = C3, C4, L1, R1, C3_1, C3_2, C4_1, C4_2, L1_1, L1_2, R1_1, R1_2, C3_3, C3_4, C4_3, C4_4, L1_3, L1_4, R1_3, R1_4, C3_1_1, C3_1_2, C3_2_1, C3_2_2, C4_1_1, C4_1_2, C4_2_1, C4_2_2, L1_1_1, L1_1_2, L1_2_1, L1_2_2, R1_1_1, R1_1_2, R1_2_1, R1_2_2
  group Group3 = Rectangle1, Rectangle2, Rectangle21, Rectangle22, Rectangle1_1, Rectangle1_2, Rectangle2_1, Rectangle2_2, Rectangle21_1, Rectangle21_2, Rectangle22_1, Rectangle22_2, Rectangle1_3, Rectangle1_4, Rectangle2_3, Rectangle2_4, Rectangle21_3, Rectangle21_4, Rectangle22_3, Rectangle22_4, Rectangle1_1_1, Rectangle1_1_2, Rectangle1_2_1, Rectangle1_2_2, Rectangle2_1_1, Rectangle2_1_2, Rectangle2_2_1, Rectangle2_2_2, Rectangle21_1_1, Rectangle21_1_2, Rectangle21_2_1, Rectangle21_2_2, Rectangle22_1_1, Rectangle22_1_2, Rectangle22_2_1, Rectangle22_2_2
  group metasurface = Box2
boundaries and excitations:
  Rad1: Radiation Objects=Box1
  PerfE1: Perfect E Objects=[Rectangle13..Rectangle16]
  PerfE2: Perfect E Objects=[Rectangle9..Rectangle12]
  meta_R: Lumped RLC Objects=[R, R1, R_1, R1_2, R_2, R_2_1, R1_2_1, R_1_1, R1_1_1, R_3, R1_3, R1_4, R_4, R1_1_2, R1_2_2, R_1_2, R_2_2] CurrentLine{(0, -29.25, 5.8) -> (-0.5, -29.25, 5.8)} RLC_Type=Serial Resistance=15kOhm Capacitance=32pF
  meta_C1: Lumped RLC Objects=[C1, C3, C3_1, C1_1, C3_2, C1_2, C1_2_1, C3_2_1, C1_1_1, C3_1_1, C1_3, C3_3, C3_4, C1_4, C3_1_2, C1_1_2, C3_2_2, C1_2_2] CurrentLine{(-21, -29.25, 5.8) -> (-21.5, -29.25, 5.8)} RLC_Type=Serial Capacitance=32pF
  meta_C2: Lumped RLC Objects=[C2, C4_1, C4, C2_1, C4_2, C2_2, C2_2_1, C4_2_1, C2_1_1, C4_1_1, C2_3, C4_3, C2_2_2, C4_2_2, C2_1_2, C4_1_2, C2_4, C4_4] CurrentLine{(-19.25, 9.25, 5.4) -> (-19.75, 9.25, 5.4)} RLC_Type=Serial Capacitance=32pF
  meta_L: Lumped RLC Objects=[L1, L, L1_1, L1_2, L_1, L_2, L_2_1, L1_2_1, L_1_1, L1_1_1, L_3, L1_3, L1_4, L_4, L1_1_2, L_1_2, L1_2_2, L_2_2] CurrentLine{(-20.5, -29.25, 5.8) -> (-21, -29.25, 5.8)} RLC_Type=Serial Inductance=0.4nH
  meta_perfE: Perfect E Objects=[Rectangle22_2_2, Rectangle2_2_2, Rectangle2_2_1, Rectangle21_2_2, Rectangle22_2_1, Rectangle1_2_2, Rectangle21_2_1, Rectangle1_2_1, Rectangle2_2, Rectangle22_2, Rectangle21_2, Rectangle1_2, Rectangle2_1, Rectangle22_1, Rectangle21_1, Rectangle1_1, Rectangle21_1_1, Rectangle2_1_1, Rectangle1_1_1, Rectangle22_1_1, Rectangle21_1_2, Rectangle2_1_2, Rectangle22_1_2, Rectangle1_1_2, Rectangle2_4, Rectangle21_4, Rectangle22_3, Rectangle2_3, Rectangle21_3, Rectangle22, Rectangle2, Rectangle21, Rectangle1, Rectangle1_3, Rectangle1_4, Rectangle22_4]
  1: Lumped Port Objects=Port LumpedPortType=Modal Modes{Mode1{IntLine{(0, -40, -6.6) -> (0, -40, -5)} CharImp=Zpi RenormImp=50ohm}} Impedance=50ohm
setups:
  Setup1: HfssDriven Frequency=2.4GHz MaxDeltaS=0.02 MaximumPasses=6 MinimumPasses=1 MinimumConvergedPasses=1 PercentRefinement=30 BasisOrder=1 PortAccuracy=2 DrivenSolverType="Direct Solver"
    sweep Sweep: 1.2GHz to 7GHz, 101 points; Type=Fast SaveFields
source amplitudes:
  1:1: 1V 0deg
radiation setups:
  Infinite Sphere1: Infinite Sphere Theta=0deg..360deg step 2deg Phi=-180deg..180deg step 2deg
reports:
  S Parameter Plot1: dB(S(1,1)) vs Freq on Setup1 : Sweep; markers m1 at 2.592GHz, m2 at 2.592GHz, MX1 at x=2.4047109e+09, MY1 at y=-10
  Directivity Plot1: dB(DirTotal) vs Phi, Theta on Setup1 : LastAdaptive, Infinite Sphere1 [Freq=2.4GHz]
  S Parameter Plot2: dB(S(1,1)) vs Freq on Setup1 : Sweep; markers MX1 at x=2.3926941e+09, MX2 at x=2.5890411e+09, MY1 at y=-9.90909
